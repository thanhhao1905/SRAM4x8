* NGSPICE file created from Sram_6T_bitcell.ext - technology: sky130A

.subckt Sram_6T_bitcell VDD GND WL Q BLB QB BL
X0 QB Q GND GND sky130_fd_pr__nfet_01v8 ad=0.15 pd=1.1 as=0.1625 ps=1.15 w=0.5 l=0.15
**devattr s=1625,115 d=1500,110
X1 VDD QB Q VDD sky130_fd_pr__pfet_01v8 ad=0.325 pd=1.65 as=0.55 ps=3.1 w=1 l=0.15
**devattr s=5500,310 d=3250,165
X2 Q WL BL GND sky130_fd_pr__nfet_01v8 ad=0.15 pd=1.1 as=0.35 ps=2.4 w=0.5 l=0.15
**devattr s=3500,240 d=1500,110
X3 BLB WL QB GND sky130_fd_pr__nfet_01v8 ad=0.275 pd=2.1 as=0.15 ps=1.1 w=0.5 l=0.15
**devattr s=1500,110 d=2750,210
X4 GND QB Q GND sky130_fd_pr__nfet_01v8 ad=0.1625 pd=1.15 as=0.15 ps=1.1 w=0.5 l=0.15
**devattr s=1500,110 d=1625,115
X5 QB Q VDD VDD sky130_fd_pr__pfet_01v8 ad=0.6 pd=3.2 as=0.325 ps=1.65 w=1 l=0.15
**devattr s=3250,165 d=6000,320
C0 QB VDD 0.18227f
C1 QB BLB 0.06487f
C2 WL BL 0.01373f
C3 Q WL 0.02538f
C4 Q BL 0.05723f
C5 WL VDD 0.01194f
C6 VDD BL 0.0231f
C7 WL BLB 0.01369f
C8 BLB BL 0.00587f
C9 WL QB 0.02585f
C10 QB BL 0.00351f
C11 Q VDD 0.14919f
C12 Q BLB 0.00233f
C13 Q QB 0.23677f
C14 VDD BLB 0.0097f
C15 BLB GND 0.14598f
C16 BL GND 0.13502f
C17 WL GND 1.01113f
C18 Q GND 0.40129f
C19 QB GND 0.35491f
C20 VDD GND 1.03671f
.ends
